ADE simulation setup
Run mode: Single Run, Sweeps and Corners
Tests:
  PAUE_VLSI_KS_PROJEKT_DIFF_AMP_STAB_test_1 (off): PAUE_VLSI_KS_PROJEKT/DIFF_AMP_STAB_test/schematic, simulator spectre
    Variables: AC = 500m; dac_bit = 0:1:31; IREF_CONST = 1.8u; IREF_DAC = 0.4u; VDD = 1.8; vdc_in = 1.15
    Outputs: /OUT; (1.8 * nil); ref_power; amp_power; (amp_power / (amp_power + ref_power)); Amp Power; (bandwidth VF("/OUT")); bandwidth(VF("/OUT") 3 "low"); /IN_P
  PAUE_VLSI_KS_PROJEKT_DIFF_AMP_STAB_test_1_1: PAUE_VLSI_KS_PROJEKT/DIFF_AMP_STAB_test/config, simulator spectre
    Variables: AC = 0; dac_bit = 0 10 20 31; IREF_CONST = 1.8u; IREF_DAC = 0.52u; vdc_in = 1.15; VDD = 1.8
    Outputs: /OUT; (1.8 * nil); ref_power; amp_power; (amp_power / (amp_power + ref_power)); Amp Power; (bandwidth VF("/OUT")); bandwidth(VF("/OUT") 3 "low"); /IN_P
Global variables:
  CONFIG/PAUE_VLSI_KS_PROJEKT/DIFF_AMP_STAB = av_extracted schematic
