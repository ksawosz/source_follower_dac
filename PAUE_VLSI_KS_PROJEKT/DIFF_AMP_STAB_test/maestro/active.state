ADE simulation setup
Test PAUE_VLSI_KS_PROJEKT_DIFF_AMP_STAB_test_1: PAUE_VLSI_KS_PROJEKT/DIFF_AMP_STAB_test/schematic, simulator spectre
  Models: /cad/dk/umc180oa/cds/UMC_18_CMOS/../Models/Spectre/mm180_bjt_v121.lib.scs[tt_bip], /cad/dk/umc180oa/cds/UMC_18_CMOS/../Models/Spectre/mm180_mimcap_v101.lib.scs[mimcaps_typ], /cad/dk/umc180oa/cds/UMC_18_CMOS/../Models/Spectre/mm180_reg18bpw_v123.lib.scs[tt], /cad/dk/umc180oa/cds/UMC_18_CMOS/../Models/Spectre/mm180_reg33bpw_v123.lib.scs[tt], /cad/dk/umc180oa/cds/UMC_18_CMOS/../Models/Spectre/mm180_res_v141.lib.scs[res_typ], /cad/dk/umc180oa/cds/UMC_18_CMOS/../Models/Spectre/mm180_lvt18_v113.lib.scs[tt], /cad/dk/umc180oa/cds/UMC_18_CMOS/../Models/Spectre/mm180_lvt33_v113.lib.scs[tt], /cad/dk/umc180oa/cds/UMC_18_CMOS/../Models/Spectre/mm180_reg18_v124.lib.scs[tt], /cad/dk/umc180oa/cds/UMC_18_CMOS/../Models/Spectre/mm180_reg33_v114.lib.scs[tt], /cad/dk/umc180oa/cds/UMC_18_CMOS/../Models/Spectre/mm180_zvt18_v121.lib.scs[tt], /cad/dk/umc180oa/cds/UMC_18_CMOS/../Models/Spectre/mm180_zvt33_v113.lib.scs[tt], /cad/dk/umc180oa/cds/UMC_18_CMOS/../Models/Spectre/core_rf_v2d4.lib.scs[tt], /cad/dk/umc180oa/cds/UMC_18_CMOS/../Models/Spectre/io_rf_v2d3.lib.scs[tt], /cad/dk/umc180oa/cds/UMC_18_CMOS/../Models/Spectre/l_slcr20k_rf_v2d3.lib.scs[typ], /cad/dk/umc180oa/cds/UMC_18_CMOS/../Models/Spectre/mimcapm_rf_v2d3.lib.scs[typ], /cad/dk/umc180oa/cds/UMC_18_CMOS/../Models/Spectre/pad_rf_v2d3.lib.scs[typ], /cad/dk/umc180oa/cds/UMC_18_CMOS/../Models/Spectre/rnhr_rf_v2d4.lib.scs[typ], /cad/dk/umc180oa/cds/UMC_18_CMOS/../Models/Spectre/rnnpo_rf_v2d4.lib.scs[typ], /cad/dk/umc180oa/cds/UMC_18_CMOS/../Models/Spectre/rnppo_rf_v2d4.lib.scs[typ], /cad/dk/umc180oa/cds/UMC_18_CMOS/../Models/Spectre/vardiop_rf_v2d3.lib.scs[typ], /cad/dk/umc180oa/cds/UMC_18_CMOS/../Models/Spectre/varmis_18_rf_v2d3.lib.scs[typ], /cad/dk/umc180oa/cds/UMC_18_CMOS/../Models/Spectre/mm180_diode_v113.mdl.scs
  Variables: vdc_in = 1.15; AC = 500m; dac_bit = 31; IREF_CONST = 1.8u; IREF_DAC = 0.4u; VDD = 1.8
  Temperature: 27
  Analysis ac: start=1M stop=1G dec=50
  Output Phase Margin = getData("phaseMargin" ?result "stb_margin")
  Output a = OP("/I2/M7" "id") (unticked)
  Output b = OP("/I2/M8" "id") (unticked)
  Output c = OP("/I2/M2" "id") (unticked)
  Output d = OP("/I2/M3" "id") (unticked)
  Output e = OP("/I2/M5" "id") (unticked)
  Output ref_power = (1.8 * (a + b)) (unticked)
  Output amp_power = (1.8 * (c + d + e)) (unticked)
  Output Amp Power = ((amp_power / (amp_power + ref_power)) * 100) (unticked)
  Output bandwidth(VF("/OUT") 3 "low")
  Output output noise; V / sqrt(Hz) = getData("out" ?result "noise") (unticked)
  Output input noise; V / sqrt(Hz) = getData("in" ?result "noise") (unticked)
  Output Loop Gain dB20 = db(mag(getData("loopGain" ?result "stb"))) (unticked)
Test PAUE_VLSI_KS_PROJEKT_DIFF_AMP_STAB_test_1_1: PAUE_VLSI_KS_PROJEKT/DIFF_AMP_STAB_test/config, simulator spectre
  Models: /cad/dk/umc180oa/cds/UMC_18_CMOS/../Models/Spectre/mm180_bjt_v121.lib.scs[tt_bip], /cad/dk/umc180oa/cds/UMC_18_CMOS/../Models/Spectre/mm180_mimcap_v101.lib.scs[mimcaps_typ], /cad/dk/umc180oa/cds/UMC_18_CMOS/../Models/Spectre/mm180_reg18bpw_v123.lib.scs[tt], /cad/dk/umc180oa/cds/UMC_18_CMOS/../Models/Spectre/mm180_reg33bpw_v123.lib.scs[tt], /cad/dk/umc180oa/cds/UMC_18_CMOS/../Models/Spectre/mm180_res_v141.lib.scs[res_typ], /cad/dk/umc180oa/cds/UMC_18_CMOS/../Models/Spectre/mm180_lvt18_v113.lib.scs[tt], /cad/dk/umc180oa/cds/UMC_18_CMOS/../Models/Spectre/mm180_lvt33_v113.lib.scs[tt], /cad/dk/umc180oa/cds/UMC_18_CMOS/../Models/Spectre/mm180_reg18_v124.lib.scs[tt], /cad/dk/umc180oa/cds/UMC_18_CMOS/../Models/Spectre/mm180_reg33_v114.lib.scs[tt], /cad/dk/umc180oa/cds/UMC_18_CMOS/../Models/Spectre/mm180_zvt18_v121.lib.scs[tt], /cad/dk/umc180oa/cds/UMC_18_CMOS/../Models/Spectre/mm180_zvt33_v113.lib.scs[tt], /cad/dk/umc180oa/cds/UMC_18_CMOS/../Models/Spectre/core_rf_v2d4.lib.scs[tt], /cad/dk/umc180oa/cds/UMC_18_CMOS/../Models/Spectre/io_rf_v2d3.lib.scs[tt], /cad/dk/umc180oa/cds/UMC_18_CMOS/../Models/Spectre/l_slcr20k_rf_v2d3.lib.scs[typ], /cad/dk/umc180oa/cds/UMC_18_CMOS/../Models/Spectre/mimcapm_rf_v2d3.lib.scs[typ], /cad/dk/umc180oa/cds/UMC_18_CMOS/../Models/Spectre/pad_rf_v2d3.lib.scs[typ], /cad/dk/umc180oa/cds/UMC_18_CMOS/../Models/Spectre/rnhr_rf_v2d4.lib.scs[typ], /cad/dk/umc180oa/cds/UMC_18_CMOS/../Models/Spectre/rnnpo_rf_v2d4.lib.scs[typ], /cad/dk/umc180oa/cds/UMC_18_CMOS/../Models/Spectre/rnppo_rf_v2d4.lib.scs[typ], /cad/dk/umc180oa/cds/UMC_18_CMOS/../Models/Spectre/vardiop_rf_v2d3.lib.scs[typ], /cad/dk/umc180oa/cds/UMC_18_CMOS/../Models/Spectre/varmis_18_rf_v2d3.lib.scs[typ], /cad/dk/umc180oa/cds/UMC_18_CMOS/../Models/Spectre/mm180_diode_v113.mdl.scs
  Variables: AC = 0; dac_bit = 0.0; IREF_CONST = 1.8u; IREF_DAC = 0.52u; vdc_in = 1.15; VDD = 1.8
  Temperature: 27
  Analysis ac: start=1M stop=1G dec=50
  Analysis stb: start=10 stop=1G dec=100 probe=/IPRB0 stbProbeMode=differential
  Output Phase Margin = getData("phaseMargin" ?result "stb_margin")
  Output a = OP("/I2/M7" "id") (unticked)
  Output b = OP("/I2/M8" "id") (unticked)
  Output c = OP("/I2/M2" "id") (unticked)
  Output d = OP("/I2/M3" "id") (unticked)
  Output e = OP("/I2/M5" "id") (unticked)
  Output ref_power = (1.8 * (a + b)) (unticked)
  Output amp_power = (1.8 * (c + d + e)) (unticked)
  Output Amp Power = ((amp_power / (amp_power + ref_power)) * 100) (unticked)
  Output bandwidth(VF("/OUT") 3 "low")
  Output output noise; V / sqrt(Hz) = getData("out" ?result "noise") (unticked)
  Output input noise; V / sqrt(Hz) = getData("in" ?result "noise") (unticked)
  Output Loop Gain dB20 = db(mag(getData("loopGain" ?result "stb"))) (unticked)
Run mode: Single Run, Sweeps and Corners
Global variables:
  CONFIG/PAUE_VLSI_KS_PROJEKT/DIFF_AMP_STAB = av_extracted schematic
Setup values for test PAUE_VLSI_KS_PROJEKT_DIFF_AMP_STAB_test_1: dac_bit = 0:1:31
Setup values for test PAUE_VLSI_KS_PROJEKT_DIFF_AMP_STAB_test_1_1: dac_bit = 0 10 20 31
Disabled tests: PAUE_VLSI_KS_PROJEKT_DIFF_AMP_STAB_test_1
